ADE simulation setup
Run mode: Monte Carlo Sampling
Tests:
  ECE203:Ins_amp_model:1: ECE203/Ins_amp_model/schematic, simulator spectre
Global variables:
  gain = 5000
  p5vonly = 0
  phires = 0
Monte Carlo Sampling options: mcmethod=all, mcnumpoints=100
